* Closed-loop buck, gain passed in via -D AGAIN=...
.param fsw=500k
.param Tsw={1/fsw}
.param Vin=12
.param Vref=0.5

Vsrc in 0 DC {Vin}

Iramp 0 ramp DC 0.5m
Cramp ramp 0 1n IC=0
Vreset rstn 0 PULSE(0 1 {Tsw-50n} 1n 1n 50n {Tsw})
Sreset ramp 0 rstn 0 RSWmod
.model RSWmod SW(Ron=1 Roff=1Meg Vt=0.5 Vh=0)

Vrefsrc vref 0 DC {Vref}
Rfb1 out vfb 5.6k
Rfb2 vfb 0 1k

Bea ctrl 0 V = max( 0, min( 1, AGAIN*(v(vref) - v(vfb)) ) )
Bpwm pwm 0 V = 0.5*(1 + tanh(200*(v(ctrl) - v(ramp))))
Bghi ghi 0 V = v(pwm)
Bglo glo 0 V = 1 - v(pwm)

Shi in sw ghi 0 SWmod
Slo sw 0 glo 0 SWmod
.model SWmod SW(Ron=10m Roff=1Meg Vt=0.5 Vh=0.1)

L1 sw out 10u
Resr out outc 10m
C1 outc 0 100u
Rload out 0 3.3

.tran 20n 2m uic

.control
run
wrdata closed_g{AGAIN}.txt v(out)
.endc

.end
