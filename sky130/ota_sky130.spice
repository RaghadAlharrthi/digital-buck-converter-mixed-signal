* 5-transistor OTA in SKY130 (real foundry models)
* Differential pair (M1,M2) + PMOS mirror load (M3,M4) + tail (M5)

* NOTE: edit this path to your local SKY130 PDK (volare) install
.lib /home/raghad/.volare/sky130A/libs.tech/combined/sky130.lib.spice tt

.param VDD=1.8
.param Vcm=0.9

Vdd  vdd 0 DC {VDD}
Vref vref 0 DC {Vcm}
Vfb  vfb  0 DC {Vcm}
Vbias vb 0 DC 0.8

* Differential pair (NMOS): drain gate source body
XM1 outb vref tail 0 sky130_fd_pr__nfet_01v8 L=0.5 W=4 nf=1
XM2 out  vfb  tail 0 sky130_fd_pr__nfet_01v8 L=0.5 W=4 nf=1

* PMOS current mirror load
XM3 outb outb vdd vdd sky130_fd_pr__pfet_01v8 L=0.5 W=8 nf=1
XM4 out  outb vdd vdd sky130_fd_pr__pfet_01v8 L=0.5 W=8 nf=1

* Tail current source (NMOS)
XM5 tail vb 0 0 sky130_fd_pr__nfet_01v8 L=0.5 W=8 nf=1

.dc Vfb 0.85 0.95 0.0005

.control
run
meas dc out_low  FIND v(out) AT=0.88
meas dc out_high FIND v(out) AT=0.92
wrdata sky130_ota_sweep.txt v(out)
.endc

.end
